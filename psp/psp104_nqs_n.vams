`include "psp104_nqs.va"

paramset PSPNQS104VA_N PSPNQS104VA
	.TYPE = 1;
endparamset
