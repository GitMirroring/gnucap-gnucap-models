`include "psp104.va"

paramset PSP104VA_N PSP104VA
	.TYPE = 1;
endparamset
